* pcbpilot sim analog — block A3 sallen-key-lowpass (U1:B) mode mc
* generated from schematic connectivity; rails from pcbpilot sim power (typical scenario)
.include "pcbpilot-generic.lib"
V_n__5v n__5v 0 DC 5
C_c2 n_sk_x n_filt_out 1e-08
C_c3 n_sk_p 0 1e-08
C_c4 n_adc_in 0 1e-09
R_r4 n_buf_out n_sk_x 10000
R_r5 n_sk_x n_sk_p 10000
R_r6 n_filt_out n_adc_in 100
X_u1_b n_sk_p n_filt_out n__5v 0 n_filt_out x_u1_b_oa x_u1_b_oi PCBPILOT_OPAMP params: gbw=1e+06 aol=398107 sr=600000 vos=0.0045 p2=3e+06 hp=0.025 hn=0.025 zout=100
V_LINK_u1_b x_u1_b_oa x_u1_b_oi DC 0
C_ADCPIN n_adc_in 0 7e-12
V_STIM n_buf_out 0 DC 2.0525 AC 1
.options noacct rshunt=1e12
.control
set filetype=ascii
set wr_singlescale
set wr_vecnames
option numdgt=10
alter c_c2 = 9.9096e-09
alter c_c3 = 1.03226e-08
alter c_c4 = 1.1e-09
alter r_r4 = 10023.7
alter r_r5 = 9964.06
alter r_r6 = 100.566
ac dec 40 1.02431 2e+07
wrdata A3-mc-mc000.txt v(n_filt_out)
alter c_c2 = 1.06e-08
alter c_c3 = 1.01048e-08
alter c_c4 = 9.99331e-10
alter r_r4 = 10019.2
alter r_r5 = 10042.9
alter r_r6 = 100.336
ac dec 40 1.02431 2e+07
wrdata A3-mc-mc001.txt v(n_filt_out)
alter c_c2 = 1.02357e-08
alter c_c3 = 1.00634e-08
alter c_c4 = 1.01925e-09
alter r_r4 = 9976.97
alter r_r5 = 10021.6
alter r_r6 = 99.9236
ac dec 40 1.02431 2e+07
wrdata A3-mc-mc002.txt v(n_filt_out)
alter c_c2 = 9.48858e-09
alter c_c3 = 9.84053e-09
alter c_c4 = 1.00286e-09
alter r_r4 = 9984.36
alter r_r5 = 9942.65
alter r_r6 = 99.8206
ac dec 40 1.02431 2e+07
wrdata A3-mc-mc003.txt v(n_filt_out)
alter c_c2 = 1.01221e-08
alter c_c3 = 9.92054e-09
alter c_c4 = 1.05953e-09
alter r_r4 = 10013.2
alter r_r5 = 10047
alter r_r6 = 99.2345
ac dec 40 1.02431 2e+07
wrdata A3-mc-mc004.txt v(n_filt_out)
alter c_c2 = 9.59722e-09
alter c_c3 = 1.02946e-08
alter c_c4 = 9.90548e-10
alter r_r4 = 9987.64
alter r_r5 = 10008.7
alter r_r6 = 100.361
ac dec 40 1.02431 2e+07
wrdata A3-mc-mc005.txt v(n_filt_out)
alter c_c2 = 9.81306e-09
alter c_c3 = 9.79086e-09
alter c_c4 = 9.88945e-10
alter r_r4 = 10006.2
alter r_r5 = 10021.4
alter r_r6 = 99.6732
ac dec 40 1.02431 2e+07
wrdata A3-mc-mc006.txt v(n_filt_out)
alter c_c2 = 9.58827e-09
alter c_c3 = 1.02302e-08
alter c_c4 = 1.00152e-09
alter r_r4 = 9970.46
alter r_r5 = 10027
alter r_r6 = 99.8262
ac dec 40 1.02431 2e+07
wrdata A3-mc-mc007.txt v(n_filt_out)
alter c_c2 = 9.74191e-09
alter c_c3 = 1.00683e-08
alter c_c4 = 9.82961e-10
alter r_r4 = 10031.7
alter r_r5 = 9998.42
alter r_r6 = 100.282
ac dec 40 1.02431 2e+07
wrdata A3-mc-mc008.txt v(n_filt_out)
alter c_c2 = 1.04931e-08
alter c_c3 = 1.02488e-08
alter c_c4 = 9.98733e-10
alter r_r4 = 10030.5
alter r_r5 = 9995.22
alter r_r6 = 100.005
ac dec 40 1.02431 2e+07
wrdata A3-mc-mc009.txt v(n_filt_out)
alter c_c2 = 1.01573e-08
alter c_c3 = 1.02968e-08
alter c_c4 = 9.70273e-10
alter r_r4 = 9997.76
alter r_r5 = 9992.36
alter r_r6 = 99.6523
ac dec 40 1.02431 2e+07
wrdata A3-mc-mc010.txt v(n_filt_out)
alter c_c2 = 1.0128e-08
alter c_c3 = 1.01676e-08
alter c_c4 = 9.92938e-10
alter r_r4 = 10011.4
alter r_r5 = 9999.74
alter r_r6 = 99.9424
ac dec 40 1.02431 2e+07
wrdata A3-mc-mc011.txt v(n_filt_out)
alter c_c2 = 9.97055e-09
alter c_c3 = 1.05487e-08
alter c_c4 = 9.85452e-10
alter r_r4 = 9982.54
alter r_r5 = 9946.25
alter r_r6 = 100.063
ac dec 40 1.02431 2e+07
wrdata A3-mc-mc012.txt v(n_filt_out)
alter c_c2 = 9.92019e-09
alter c_c3 = 9.96719e-09
alter c_c4 = 9.37454e-10
alter r_r4 = 9918.13
alter r_r5 = 9943.69
alter r_r6 = 100.497
ac dec 40 1.02431 2e+07
wrdata A3-mc-mc013.txt v(n_filt_out)
alter c_c2 = 9.61131e-09
alter c_c3 = 9.96508e-09
alter c_c4 = 9.80844e-10
alter r_r4 = 9999.64
alter r_r5 = 9990.7
alter r_r6 = 99.9667
ac dec 40 1.02431 2e+07
wrdata A3-mc-mc014.txt v(n_filt_out)
alter c_c2 = 9.27124e-09
alter c_c3 = 9.84031e-09
alter c_c4 = 9.77979e-10
alter r_r4 = 10012
alter r_r5 = 9976.89
alter r_r6 = 100.33
ac dec 40 1.02431 2e+07
wrdata A3-mc-mc015.txt v(n_filt_out)
alter c_c2 = 9.89213e-09
alter c_c3 = 1.02888e-08
alter c_c4 = 9.96335e-10
alter r_r4 = 9968.48
alter r_r5 = 9988.72
alter r_r6 = 100.271
ac dec 40 1.02431 2e+07
wrdata A3-mc-mc016.txt v(n_filt_out)
alter c_c2 = 9.80269e-09
alter c_c3 = 9.86798e-09
alter c_c4 = 1.00672e-09
alter r_r4 = 10040.7
alter r_r5 = 10034.1
alter r_r6 = 99.7768
ac dec 40 1.02431 2e+07
wrdata A3-mc-mc017.txt v(n_filt_out)
alter c_c2 = 1.00934e-08
alter c_c3 = 1.03726e-08
alter c_c4 = 9.97066e-10
alter r_r4 = 10036.8
alter r_r5 = 9972.59
alter r_r6 = 100.428
ac dec 40 1.02431 2e+07
wrdata A3-mc-mc018.txt v(n_filt_out)
alter c_c2 = 1.00454e-08
alter c_c3 = 1.00951e-08
alter c_c4 = 1.00937e-09
alter r_r4 = 10013.6
alter r_r5 = 10021.1
alter r_r6 = 100.253
ac dec 40 1.02431 2e+07
wrdata A3-mc-mc019.txt v(n_filt_out)
alter c_c2 = 1.03492e-08
alter c_c3 = 1.02304e-08
alter c_c4 = 1.0034e-09
alter r_r4 = 10018
alter r_r5 = 10038.5
alter r_r6 = 99.9894
ac dec 40 1.02431 2e+07
wrdata A3-mc-mc020.txt v(n_filt_out)
alter c_c2 = 9.67561e-09
alter c_c3 = 9.70745e-09
alter c_c4 = 9.67396e-10
alter r_r4 = 10006.3
alter r_r5 = 9974.59
alter r_r6 = 99.9116
ac dec 40 1.02431 2e+07
wrdata A3-mc-mc021.txt v(n_filt_out)
alter c_c2 = 9.96412e-09
alter c_c3 = 1.03808e-08
alter c_c4 = 1.00273e-09
alter r_r4 = 10015.2
alter r_r5 = 9979.84
alter r_r6 = 99.9359
ac dec 40 1.02431 2e+07
wrdata A3-mc-mc022.txt v(n_filt_out)
alter c_c2 = 1.02912e-08
alter c_c3 = 9.65272e-09
alter c_c4 = 1.00808e-09
alter r_r4 = 9975.9
alter r_r5 = 9964.83
alter r_r6 = 100.279
ac dec 40 1.02431 2e+07
wrdata A3-mc-mc023.txt v(n_filt_out)
alter c_c2 = 9.94598e-09
alter c_c3 = 9.91624e-09
alter c_c4 = 9.70295e-10
alter r_r4 = 9957.69
alter r_r5 = 10010.1
alter r_r6 = 99.6397
ac dec 40 1.02431 2e+07
wrdata A3-mc-mc024.txt v(n_filt_out)
alter c_c2 = 1.01947e-08
alter c_c3 = 9.95109e-09
alter c_c4 = 1.01639e-09
alter r_r4 = 9977.47
alter r_r5 = 9924.47
alter r_r6 = 99.9526
ac dec 40 1.02431 2e+07
wrdata A3-mc-mc025.txt v(n_filt_out)
alter c_c2 = 1.01278e-08
alter c_c3 = 9.82377e-09
alter c_c4 = 9.91675e-10
alter r_r4 = 10057.5
alter r_r5 = 10015.8
alter r_r6 = 100.423
ac dec 40 1.02431 2e+07
wrdata A3-mc-mc026.txt v(n_filt_out)
alter c_c2 = 9.59643e-09
alter c_c3 = 9.66489e-09
alter c_c4 = 1.02619e-09
alter r_r4 = 10045.9
alter r_r5 = 9996.97
alter r_r6 = 99.6324
ac dec 40 1.02431 2e+07
wrdata A3-mc-mc027.txt v(n_filt_out)
alter c_c2 = 1.05324e-08
alter c_c3 = 1.01668e-08
alter c_c4 = 1.02013e-09
alter r_r4 = 9985.58
alter r_r5 = 9962.22
alter r_r6 = 100.287
ac dec 40 1.02431 2e+07
wrdata A3-mc-mc028.txt v(n_filt_out)
alter c_c2 = 1.01349e-08
alter c_c3 = 9.93957e-09
alter c_c4 = 1.06318e-09
alter r_r4 = 10016.8
alter r_r5 = 10014.9
alter r_r6 = 100.007
ac dec 40 1.02431 2e+07
wrdata A3-mc-mc029.txt v(n_filt_out)
alter c_c2 = 1.02603e-08
alter c_c3 = 9.50465e-09
alter c_c4 = 9.6208e-10
alter r_r4 = 9991.59
alter r_r5 = 10046.6
alter r_r6 = 99.7067
ac dec 40 1.02431 2e+07
wrdata A3-mc-mc030.txt v(n_filt_out)
alter c_c2 = 9.68694e-09
alter c_c3 = 1.02074e-08
alter c_c4 = 9.84512e-10
alter r_r4 = 9973.15
alter r_r5 = 10050.4
alter r_r6 = 99.6994
ac dec 40 1.02431 2e+07
wrdata A3-mc-mc031.txt v(n_filt_out)
alter c_c2 = 1.01733e-08
alter c_c3 = 1.02061e-08
alter c_c4 = 9.72731e-10
alter r_r4 = 9963.86
alter r_r5 = 10023
alter r_r6 = 100.147
ac dec 40 1.02431 2e+07
wrdata A3-mc-mc032.txt v(n_filt_out)
alter c_c2 = 9.67135e-09
alter c_c3 = 9.90415e-09
alter c_c4 = 9.93174e-10
alter r_r4 = 9989.3
alter r_r5 = 9951.61
alter r_r6 = 100.123
ac dec 40 1.02431 2e+07
wrdata A3-mc-mc033.txt v(n_filt_out)
alter c_c2 = 1.02806e-08
alter c_c3 = 1.00644e-08
alter c_c4 = 1.04989e-09
alter r_r4 = 10052
alter r_r5 = 9967.48
alter r_r6 = 100.235
ac dec 40 1.02431 2e+07
wrdata A3-mc-mc034.txt v(n_filt_out)
alter c_c2 = 9.45765e-09
alter c_c3 = 1.01223e-08
alter c_c4 = 9.98235e-10
alter r_r4 = 10019.2
alter r_r5 = 10071.6
alter r_r6 = 100.22
ac dec 40 1.02431 2e+07
wrdata A3-mc-mc035.txt v(n_filt_out)
alter c_c2 = 1.03388e-08
alter c_c3 = 1.02192e-08
alter c_c4 = 9.34103e-10
alter r_r4 = 9969.8
alter r_r5 = 9992.92
alter r_r6 = 99.9113
ac dec 40 1.02431 2e+07
wrdata A3-mc-mc036.txt v(n_filt_out)
alter c_c2 = 1.08253e-08
alter c_c3 = 1.0436e-08
alter c_c4 = 1.01672e-09
alter r_r4 = 10024.8
alter r_r5 = 10055.4
alter r_r6 = 99.6315
ac dec 40 1.02431 2e+07
wrdata A3-mc-mc037.txt v(n_filt_out)
alter c_c2 = 9.93622e-09
alter c_c3 = 9.77949e-09
alter c_c4 = 1.03551e-09
alter r_r4 = 10021.3
alter r_r5 = 10053.5
alter r_r6 = 99.5606
ac dec 40 1.02431 2e+07
wrdata A3-mc-mc038.txt v(n_filt_out)
alter c_c2 = 9.79341e-09
alter c_c3 = 1.02831e-08
alter c_c4 = 9.9116e-10
alter r_r4 = 10005.2
alter r_r5 = 9975.21
alter r_r6 = 100.155
ac dec 40 1.02431 2e+07
wrdata A3-mc-mc039.txt v(n_filt_out)
alter c_c2 = 9.45003e-09
alter c_c3 = 9.8682e-09
alter c_c4 = 9.75999e-10
alter r_r4 = 10050.8
alter r_r5 = 10037.7
alter r_r6 = 99.9649
ac dec 40 1.02431 2e+07
wrdata A3-mc-mc040.txt v(n_filt_out)
alter c_c2 = 1.03241e-08
alter c_c3 = 9.5375e-09
alter c_c4 = 9.49295e-10
alter r_r4 = 9908.72
alter r_r5 = 9989.58
alter r_r6 = 99.4184
ac dec 40 1.02431 2e+07
wrdata A3-mc-mc041.txt v(n_filt_out)
alter c_c2 = 9.94803e-09
alter c_c3 = 9.77335e-09
alter c_c4 = 9.77432e-10
alter r_r4 = 10024.2
alter r_r5 = 9992.98
alter r_r6 = 99.4962
ac dec 40 1.02431 2e+07
wrdata A3-mc-mc042.txt v(n_filt_out)
alter c_c2 = 9.92558e-09
alter c_c3 = 1.04199e-08
alter c_c4 = 9.77567e-10
alter r_r4 = 9990.31
alter r_r5 = 10018.3
alter r_r6 = 100.107
ac dec 40 1.02431 2e+07
wrdata A3-mc-mc043.txt v(n_filt_out)
alter c_c2 = 1.00336e-08
alter c_c3 = 9.78404e-09
alter c_c4 = 9.64731e-10
alter r_r4 = 9937.09
alter r_r5 = 10007
alter r_r6 = 100.088
ac dec 40 1.02431 2e+07
wrdata A3-mc-mc044.txt v(n_filt_out)
alter c_c2 = 9.86666e-09
alter c_c3 = 9.75101e-09
alter c_c4 = 9.79171e-10
alter r_r4 = 9955.55
alter r_r5 = 10042.2
alter r_r6 = 99.6773
ac dec 40 1.02431 2e+07
wrdata A3-mc-mc045.txt v(n_filt_out)
alter c_c2 = 1.03745e-08
alter c_c3 = 1.01198e-08
alter c_c4 = 1.00026e-09
alter r_r4 = 10094.5
alter r_r5 = 10024.3
alter r_r6 = 100.234
ac dec 40 1.02431 2e+07
wrdata A3-mc-mc046.txt v(n_filt_out)
alter c_c2 = 1.01233e-08
alter c_c3 = 1.02544e-08
alter c_c4 = 1.05782e-09
alter r_r4 = 10038.3
alter r_r5 = 9951.42
alter r_r6 = 100.231
ac dec 40 1.02431 2e+07
wrdata A3-mc-mc047.txt v(n_filt_out)
alter c_c2 = 9.77869e-09
alter c_c3 = 1.06153e-08
alter c_c4 = 1.00516e-09
alter r_r4 = 10008.8
alter r_r5 = 10004.6
alter r_r6 = 99.4296
ac dec 40 1.02431 2e+07
wrdata A3-mc-mc048.txt v(n_filt_out)
alter c_c2 = 1.07338e-08
alter c_c3 = 9.872e-09
alter c_c4 = 9.85485e-10
alter r_r4 = 9978.97
alter r_r5 = 10033.1
alter r_r6 = 100.238
ac dec 40 1.02431 2e+07
wrdata A3-mc-mc049.txt v(n_filt_out)
alter c_c2 = 1.03033e-08
alter c_c3 = 9.99732e-09
alter c_c4 = 1.00722e-09
alter r_r4 = 9990.71
alter r_r5 = 9966.01
alter r_r6 = 100.185
ac dec 40 1.02431 2e+07
wrdata A3-mc-mc050.txt v(n_filt_out)
alter c_c2 = 1.03207e-08
alter c_c3 = 9.80762e-09
alter c_c4 = 9.98953e-10
alter r_r4 = 9958.13
alter r_r5 = 9992.84
alter r_r6 = 99.892
ac dec 40 1.02431 2e+07
wrdata A3-mc-mc051.txt v(n_filt_out)
alter c_c2 = 9.65221e-09
alter c_c3 = 1.04714e-08
alter c_c4 = 1.01776e-09
alter r_r4 = 10005
alter r_r5 = 9989.75
alter r_r6 = 99.7399
ac dec 40 1.02431 2e+07
wrdata A3-mc-mc052.txt v(n_filt_out)
alter c_c2 = 1.00669e-08
alter c_c3 = 9.91073e-09
alter c_c4 = 1.00276e-09
alter r_r4 = 10035.1
alter r_r5 = 10001.8
alter r_r6 = 100.126
ac dec 40 1.02431 2e+07
wrdata A3-mc-mc053.txt v(n_filt_out)
alter c_c2 = 1.02829e-08
alter c_c3 = 1.0312e-08
alter c_c4 = 1.0214e-09
alter r_r4 = 9985.13
alter r_r5 = 9984.26
alter r_r6 = 99.82
ac dec 40 1.02431 2e+07
wrdata A3-mc-mc054.txt v(n_filt_out)
alter c_c2 = 1.04151e-08
alter c_c3 = 9.73677e-09
alter c_c4 = 1.07804e-09
alter r_r4 = 9994.44
alter r_r5 = 9977.07
alter r_r6 = 99.7805
ac dec 40 1.02431 2e+07
wrdata A3-mc-mc055.txt v(n_filt_out)
alter c_c2 = 9.62266e-09
alter c_c3 = 9.79109e-09
alter c_c4 = 1.03888e-09
alter r_r4 = 10004.4
alter r_r5 = 9949.01
alter r_r6 = 100.324
ac dec 40 1.02431 2e+07
wrdata A3-mc-mc056.txt v(n_filt_out)
alter c_c2 = 1.01508e-08
alter c_c3 = 1.05945e-08
alter c_c4 = 9.69223e-10
alter r_r4 = 9990.39
alter r_r5 = 10037.4
alter r_r6 = 100.119
ac dec 40 1.02431 2e+07
wrdata A3-mc-mc057.txt v(n_filt_out)
alter c_c2 = 9.34519e-09
alter c_c3 = 1.00911e-08
alter c_c4 = 9.66898e-10
alter r_r4 = 10033.4
alter r_r5 = 9976.99
alter r_r6 = 100.469
ac dec 40 1.02431 2e+07
wrdata A3-mc-mc058.txt v(n_filt_out)
alter c_c2 = 9.67891e-09
alter c_c3 = 9.62091e-09
alter c_c4 = 9.54926e-10
alter r_r4 = 10034.2
alter r_r5 = 9992.24
alter r_r6 = 100.12
ac dec 40 1.02431 2e+07
wrdata A3-mc-mc059.txt v(n_filt_out)
alter c_c2 = 1.02159e-08
alter c_c3 = 9.90008e-09
alter c_c4 = 9.79706e-10
alter r_r4 = 9966.33
alter r_r5 = 10003.2
alter r_r6 = 99.604
ac dec 40 1.02431 2e+07
wrdata A3-mc-mc060.txt v(n_filt_out)
alter c_c2 = 9.95976e-09
alter c_c3 = 1.01263e-08
alter c_c4 = 1.00544e-09
alter r_r4 = 10045.3
alter r_r5 = 10023.5
alter r_r6 = 99.9799
ac dec 40 1.02431 2e+07
wrdata A3-mc-mc061.txt v(n_filt_out)
alter c_c2 = 9.63489e-09
alter c_c3 = 9.93431e-09
alter c_c4 = 9.85621e-10
alter r_r4 = 9990.35
alter r_r5 = 9982.29
alter r_r6 = 100.511
ac dec 40 1.02431 2e+07
wrdata A3-mc-mc062.txt v(n_filt_out)
alter c_c2 = 1.05885e-08
alter c_c3 = 1.00053e-08
alter c_c4 = 9.82799e-10
alter r_r4 = 9964.1
alter r_r5 = 9985.03
alter r_r6 = 99.5656
ac dec 40 1.02431 2e+07
wrdata A3-mc-mc063.txt v(n_filt_out)
alter c_c2 = 1.02038e-08
alter c_c3 = 1.03433e-08
alter c_c4 = 1.04142e-09
alter r_r4 = 10029.9
alter r_r5 = 10002.5
alter r_r6 = 100.046
ac dec 40 1.02431 2e+07
wrdata A3-mc-mc064.txt v(n_filt_out)
alter c_c2 = 9.96522e-09
alter c_c3 = 1.02932e-08
alter c_c4 = 1.00847e-09
alter r_r4 = 10046.6
alter r_r5 = 10032.7
alter r_r6 = 99.7891
ac dec 40 1.02431 2e+07
wrdata A3-mc-mc065.txt v(n_filt_out)
alter c_c2 = 1.02057e-08
alter c_c3 = 9.79784e-09
alter c_c4 = 1.01676e-09
alter r_r4 = 10040
alter r_r5 = 9963.32
alter r_r6 = 100.761
ac dec 40 1.02431 2e+07
wrdata A3-mc-mc066.txt v(n_filt_out)
alter c_c2 = 1.02301e-08
alter c_c3 = 9.8236e-09
alter c_c4 = 9.93106e-10
alter r_r4 = 10027.7
alter r_r5 = 9996.75
alter r_r6 = 100.168
ac dec 40 1.02431 2e+07
wrdata A3-mc-mc067.txt v(n_filt_out)
alter c_c2 = 9.69355e-09
alter c_c3 = 9.93602e-09
alter c_c4 = 1.03941e-09
alter r_r4 = 10010.8
alter r_r5 = 9998.64
alter r_r6 = 99.7975
ac dec 40 1.02431 2e+07
wrdata A3-mc-mc068.txt v(n_filt_out)
alter c_c2 = 9.8693e-09
alter c_c3 = 1.07275e-08
alter c_c4 = 9.47895e-10
alter r_r4 = 9989.61
alter r_r5 = 9990.85
alter r_r6 = 100.23
ac dec 40 1.02431 2e+07
wrdata A3-mc-mc069.txt v(n_filt_out)
alter c_c2 = 1.02193e-08
alter c_c3 = 9.39803e-09
alter c_c4 = 9.5171e-10
alter r_r4 = 9998.64
alter r_r5 = 9957.64
alter r_r6 = 100.195
ac dec 40 1.02431 2e+07
wrdata A3-mc-mc070.txt v(n_filt_out)
alter c_c2 = 9.57492e-09
alter c_c3 = 9.99879e-09
alter c_c4 = 9.81586e-10
alter r_r4 = 9977.74
alter r_r5 = 10068
alter r_r6 = 100.087
ac dec 40 1.02431 2e+07
wrdata A3-mc-mc071.txt v(n_filt_out)
alter c_c2 = 1.00491e-08
alter c_c3 = 9.97596e-09
alter c_c4 = 1.00684e-09
alter r_r4 = 9976.62
alter r_r5 = 9956.17
alter r_r6 = 99.5785
ac dec 40 1.02431 2e+07
wrdata A3-mc-mc072.txt v(n_filt_out)
alter c_c2 = 1.01415e-08
alter c_c3 = 1.05004e-08
alter c_c4 = 1.01845e-09
alter r_r4 = 10027.3
alter r_r5 = 9989.44
alter r_r6 = 100.555
ac dec 40 1.02431 2e+07
wrdata A3-mc-mc073.txt v(n_filt_out)
alter c_c2 = 1.00653e-08
alter c_c3 = 1.04568e-08
alter c_c4 = 9.42039e-10
alter r_r4 = 10020.6
alter r_r5 = 10053.9
alter r_r6 = 100.173
ac dec 40 1.02431 2e+07
wrdata A3-mc-mc074.txt v(n_filt_out)
alter c_c2 = 9.9254e-09
alter c_c3 = 9.91997e-09
alter c_c4 = 1.00054e-09
alter r_r4 = 10023
alter r_r5 = 9947.24
alter r_r6 = 99.8294
ac dec 40 1.02431 2e+07
wrdata A3-mc-mc075.txt v(n_filt_out)
alter c_c2 = 1.01589e-08
alter c_c3 = 9.35502e-09
alter c_c4 = 1.02251e-09
alter r_r4 = 10036
alter r_r5 = 10022
alter r_r6 = 100.378
ac dec 40 1.02431 2e+07
wrdata A3-mc-mc076.txt v(n_filt_out)
alter c_c2 = 1.03226e-08
alter c_c3 = 9.66196e-09
alter c_c4 = 9.97203e-10
alter r_r4 = 10058.6
alter r_r5 = 9930.29
alter r_r6 = 99.7161
ac dec 40 1.02431 2e+07
wrdata A3-mc-mc077.txt v(n_filt_out)
alter c_c2 = 1.02528e-08
alter c_c3 = 9.92332e-09
alter c_c4 = 9.74576e-10
alter r_r4 = 9954.87
alter r_r5 = 10041.9
alter r_r6 = 100.611
ac dec 40 1.02431 2e+07
wrdata A3-mc-mc078.txt v(n_filt_out)
alter c_c2 = 9.99933e-09
alter c_c3 = 1.04202e-08
alter c_c4 = 1.02382e-09
alter r_r4 = 9982.85
alter r_r5 = 9960.76
alter r_r6 = 100.345
ac dec 40 1.02431 2e+07
wrdata A3-mc-mc079.txt v(n_filt_out)
alter c_c2 = 1.00296e-08
alter c_c3 = 1.00052e-08
alter c_c4 = 9.27628e-10
alter r_r4 = 9958.83
alter r_r5 = 10046.6
alter r_r6 = 100.045
ac dec 40 1.02431 2e+07
wrdata A3-mc-mc080.txt v(n_filt_out)
alter c_c2 = 1.0301e-08
alter c_c3 = 9.94013e-09
alter c_c4 = 9.53801e-10
alter r_r4 = 9991.03
alter r_r5 = 9948.16
alter r_r6 = 100.427
ac dec 40 1.02431 2e+07
wrdata A3-mc-mc081.txt v(n_filt_out)
alter c_c2 = 9.81627e-09
alter c_c3 = 1.02462e-08
alter c_c4 = 1.01641e-09
alter r_r4 = 9960.01
alter r_r5 = 10008.6
alter r_r6 = 99.6816
ac dec 40 1.02431 2e+07
wrdata A3-mc-mc082.txt v(n_filt_out)
alter c_c2 = 1.01323e-08
alter c_c3 = 9.83407e-09
alter c_c4 = 1.02942e-09
alter r_r4 = 9978.39
alter r_r5 = 9983.85
alter r_r6 = 100.344
ac dec 40 1.02431 2e+07
wrdata A3-mc-mc083.txt v(n_filt_out)
alter c_c2 = 1.0363e-08
alter c_c3 = 1.03495e-08
alter c_c4 = 1.01039e-09
alter r_r4 = 9999.77
alter r_r5 = 9988.17
alter r_r6 = 99.6519
ac dec 40 1.02431 2e+07
wrdata A3-mc-mc084.txt v(n_filt_out)
alter c_c2 = 9.8721e-09
alter c_c3 = 1.00044e-08
alter c_c4 = 1.00799e-09
alter r_r4 = 9997.78
alter r_r5 = 9984.69
alter r_r6 = 99.8459
ac dec 40 1.02431 2e+07
wrdata A3-mc-mc085.txt v(n_filt_out)
alter c_c2 = 9.81901e-09
alter c_c3 = 1.05422e-08
alter c_c4 = 1.02064e-09
alter r_r4 = 9988.18
alter r_r5 = 10018.9
alter r_r6 = 100.558
ac dec 40 1.02431 2e+07
wrdata A3-mc-mc086.txt v(n_filt_out)
alter c_c2 = 9.39122e-09
alter c_c3 = 9.83527e-09
alter c_c4 = 9.70848e-10
alter r_r4 = 10005.2
alter r_r5 = 10008.5
alter r_r6 = 99.8873
ac dec 40 1.02431 2e+07
wrdata A3-mc-mc087.txt v(n_filt_out)
alter c_c2 = 9.68711e-09
alter c_c3 = 1.00121e-08
alter c_c4 = 1.00417e-09
alter r_r4 = 9946.62
alter r_r5 = 9985
alter r_r6 = 99.2826
ac dec 40 1.02431 2e+07
wrdata A3-mc-mc088.txt v(n_filt_out)
alter c_c2 = 9.73263e-09
alter c_c3 = 1.00311e-08
alter c_c4 = 9.53937e-10
alter r_r4 = 9968.13
alter r_r5 = 10019.5
alter r_r6 = 99.8439
ac dec 40 1.02431 2e+07
wrdata A3-mc-mc089.txt v(n_filt_out)
alter c_c2 = 9.59002e-09
alter c_c3 = 9.71726e-09
alter c_c4 = 9.9919e-10
alter r_r4 = 9998.28
alter r_r5 = 9940.21
alter r_r6 = 99.7103
ac dec 40 1.02431 2e+07
wrdata A3-mc-mc090.txt v(n_filt_out)
alter c_c2 = 1.04562e-08
alter c_c3 = 9.66066e-09
alter c_c4 = 1.0034e-09
alter r_r4 = 9999.31
alter r_r5 = 9997.12
alter r_r6 = 99.9594
ac dec 40 1.02431 2e+07
wrdata A3-mc-mc091.txt v(n_filt_out)
alter c_c2 = 1.01171e-08
alter c_c3 = 9.95769e-09
alter c_c4 = 1.01748e-09
alter r_r4 = 10000.4
alter r_r5 = 10011
alter r_r6 = 100.829
ac dec 40 1.02431 2e+07
wrdata A3-mc-mc092.txt v(n_filt_out)
alter c_c2 = 9.82387e-09
alter c_c3 = 1.01374e-08
alter c_c4 = 9.73558e-10
alter r_r4 = 9988.71
alter r_r5 = 9959.22
alter r_r6 = 99.9861
ac dec 40 1.02431 2e+07
wrdata A3-mc-mc093.txt v(n_filt_out)
alter c_c2 = 9.79956e-09
alter c_c3 = 9.92487e-09
alter c_c4 = 1.00345e-09
alter r_r4 = 9969.83
alter r_r5 = 10008.2
alter r_r6 = 100.236
ac dec 40 1.02431 2e+07
wrdata A3-mc-mc094.txt v(n_filt_out)
alter c_c2 = 9.90199e-09
alter c_c3 = 9.66602e-09
alter c_c4 = 9.79337e-10
alter r_r4 = 10011.9
alter r_r5 = 9963.83
alter r_r6 = 100.064
ac dec 40 1.02431 2e+07
wrdata A3-mc-mc095.txt v(n_filt_out)
alter c_c2 = 1.02496e-08
alter c_c3 = 9.74949e-09
alter c_c4 = 9.89514e-10
alter r_r4 = 10015.9
alter r_r5 = 10046.2
alter r_r6 = 100.596
ac dec 40 1.02431 2e+07
wrdata A3-mc-mc096.txt v(n_filt_out)
alter c_c2 = 1.00959e-08
alter c_c3 = 9.94713e-09
alter c_c4 = 9.44292e-10
alter r_r4 = 10030.1
alter r_r5 = 10010.8
alter r_r6 = 100.142
ac dec 40 1.02431 2e+07
wrdata A3-mc-mc097.txt v(n_filt_out)
alter c_c2 = 1.03165e-08
alter c_c3 = 9.78402e-09
alter c_c4 = 1.02959e-09
alter r_r4 = 10035.8
alter r_r5 = 10013.7
alter r_r6 = 100.176
ac dec 40 1.02431 2e+07
wrdata A3-mc-mc098.txt v(n_filt_out)
alter c_c2 = 9.46636e-09
alter c_c3 = 9.68762e-09
alter c_c4 = 9.86882e-10
alter r_r4 = 10042.3
alter r_r5 = 10014
alter r_r6 = 99.4161
ac dec 40 1.02431 2e+07
wrdata A3-mc-mc099.txt v(n_filt_out)
quit
.endc
.end
