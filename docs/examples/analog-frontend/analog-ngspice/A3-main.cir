* pcbpilot sim analog — block A3 sallen-key-lowpass (U1:B) mode main
* generated from schematic connectivity; rails from pcbpilot sim power (typical scenario)
.include "pcbpilot-generic.lib"
V_n__5v n__5v 0 DC 5
C_c2 n_sk_x n_filt_out 1e-08
C_c3 n_sk_p 0 1e-08
C_c4 n_adc_in 0 1e-09
R_r4 n_buf_out n_sk_x 10000
R_r5 n_sk_x n_sk_p 10000
R_r6 n_filt_out n_adc_in 100
X_u1_b n_sk_p n_filt_out n__5v 0 n_filt_out x_u1_b_oa x_u1_b_oi PCBPILOT_OPAMP params: gbw=1e+06 aol=398107 sr=600000 vos=0.0045 p2=3e+06 hp=0.025 hn=0.025 zout=100
V_LINK_u1_b x_u1_b_oa x_u1_b_oi DC 0
C_ADCPIN n_adc_in 0 7e-12
V_STIM n_buf_out 0 DC 2.0525 AC 1 PULSE(2.0525 2.3025 0.00062151 6.83661e-08 6.83661e-08 1 2)
.options noacct rshunt=1e12
.control
set filetype=ascii
set wr_singlescale
set wr_vecnames
option numdgt=10
op
print v(n_filt_out) v(n_sk_p) i(v_link_u1_b)
ac dec 50 1.02431 2e+07
wrdata A3-main-ac.txt v(n_filt_out)
tran 1.70915e-06 0.00683661 0 1.70915e-06
wrdata A3-main-tran.txt v(n_filt_out) v(n_buf_out) i(v_link_u1_b)
quit
.endc
.end
